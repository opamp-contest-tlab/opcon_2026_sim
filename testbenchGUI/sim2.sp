* settings ***************
.lib 'lib/settings.lib' settings
**************************

* opamp ******************
.include 'tmp.sp'
**************************

* sr *********************
.title sr
.lib 'for_sr.lib' vpval
.lib 'lib/sr.lib' tran1
**************************
